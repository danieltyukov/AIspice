Half-wave rectifier with smoothing capacitor
V1 in 0 SINE(0 10 50)
D1 in out 1N4148
C1 out 0 100u
RL out 0 1k
.model 1N4148 D(Is=2.52n Rs=0.568 N=1.752 Cjo=4p M=0.4 tt=20n)
.tran 0 60m 0 10u
.end
