Inverting amplifier, gain -10
VIN in 0 SINE(0 100m 1k)
R1 in inv 10k
R2 inv out 100k
XU1 inv 0 out opamp Aol=100K GBW=10Meg
.subckt opamp 1 2 3
G1 0 3 2 1 {Aol}
R3 3 0 1
C3 3 0 {Aol/GBW/6.28318530717959}
.ends opamp
.tran 0 3m
.end
