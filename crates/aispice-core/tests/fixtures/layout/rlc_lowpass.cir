Second-order RLC low-pass with load
V1 in 0 AC 1
R1 in n1 50
L1 n1 out 10m
C1 out 0 1u
RL out 0 1k
.ac dec 100 100 100k
.end
