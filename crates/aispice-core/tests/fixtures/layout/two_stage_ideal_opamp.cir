Two-stage inverting amplifier with ideal op-amps
VIN in 0 SINE(0 100m 1k) AC 1
R1 in n1 10k
R2 n1 mid 47k
XU1 n1 0 mid opamp Aol=100K GBW=10Meg
R3 mid n2 10k
R4 n2 out 22k
XU2 n2 0 out opamp Aol=100K GBW=10Meg
.subckt opamp 1 2 3
G1 0 3 2 1 {Aol}
R3 3 0 1
C3 3 0 {Aol/GBW/6.28318530717959}
.ends opamp
.tran 0 5m
.end
