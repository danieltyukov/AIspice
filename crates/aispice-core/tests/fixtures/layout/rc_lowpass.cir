RC low-pass filter, fc = 1.59 kHz
V1 in 0 SINE(0 1 1k) AC 1
R1 in out 1k
C1 out 0 100n
.ac dec 50 10 1Meg
.end
