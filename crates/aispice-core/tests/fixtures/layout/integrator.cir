Active integrator with DC feedback resistor
VIN in 0 PULSE(-1 1 0 1u 1u 0.5m 1m)
R1 in inv 10k
C1 inv out 10n
R2 inv out 1Meg
XU1 inv 0 out opamp Aol=100K GBW=10Meg
.subckt opamp 1 2 3
G1 0 3 2 1 {Aol}
R3 3 0 1
C3 3 0 {Aol/GBW/6.28318530717959}
.ends opamp
.tran 0 5m
.end
