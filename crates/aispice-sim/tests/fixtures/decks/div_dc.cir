Divider dc
* V(out) = 0.75 * V1 over the sweep.
V1 in 0 10
R1 in out 1k
R2 out 0 3k
.dc V1 0 10 1
.end
