RC meas
* Measurements LTspice prints into the log, including one that fails.
V1 in 0 PULSE(0 1 0 1n 1n 1 2) AC 1
R1 in out 1k
C1 out 0 1u
.tran 0 5m 0 50u
.meas tran vmax MAX V(out)
.meas tran trise TRIG V(out) VAL=0.1 RISE=1 TARG V(out) VAL=0.9 RISE=1
.meas tran vavg AVG V(out) FROM 1m TO 2m
.meas tran never FIND V(out) WHEN V(out)=5
.end
