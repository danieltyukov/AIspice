Divider op
* 10 V across 1k over 3k: V(out) = 7.5 V, 2.5 mA.
V1 in 0 10
R1 in out 1k
R2 out 0 3k
.op
.end
