RC AC
* R=1k, C=100n: corner at 1/(2 pi R C) = 1591.549 Hz.
V1 in 0 AC 1
R1 in out 1k
C1 out 0 100n
.ac dec 10 10 100k
.end
