RC noise
* Thermal noise of 1k at low frequency: sqrt(4 k T R) = 4.07 nV/sqrt(Hz).
V1 in 0 0 AC 1
R1 in out 1k
C1 out 0 100n
.noise V(out) V1 dec 5 10 100k
.end
