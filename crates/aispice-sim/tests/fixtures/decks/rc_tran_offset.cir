RC transient offset
* Data saved from 1 ms on: LTspice stores time relative to the Offset header.
V1 in 0 PULSE(0 1 0 1n 1n 1 2)
R1 in out 1k
C1 out 0 1u
.tran 0 2m 1m 50u
.options plotwinsize=0
.end
